ADE simulation setup
Run mode: Single Run, Sweeps and Corners
Tests:
  project_tb_system_with_external_driver_1: project/tb_system_with_external_driver/schematic, simulator spectre
