ADE simulation setup
Run mode: Single Run, Sweeps and Corners
Tests:
  project_tb_state_decoder_1: project/tb_state_decoder/schematic, simulator spectre
