ADE simulation setup
Run mode: Single Run, Sweeps and Corners
Tests:
  project_tb_decoder_driver_top_1: project/tb_decoder_driver_top/schematic, simulator spectre
