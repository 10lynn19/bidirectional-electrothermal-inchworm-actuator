ADE simulation setup
Run mode: Single Run, Sweeps and Corners
Tests:
  project_fsm_state_ctl_1: project/fsm_state_ctl/schematic, simulator spectre
