ADE simulation setup
Run mode: Single Run, Sweeps and Corners
Tests:
  project_tb_external_hv_driver_1ch_1: project/tb_external_hv_driver_1ch/schematic, simulator spectre
