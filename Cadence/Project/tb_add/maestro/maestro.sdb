ADE simulation setup
Run mode: Single Run, Sweeps and Corners
Tests:
  project_tb_add_1: project/tb_add/schematic, simulator spectre
