ADE simulation setup
Run mode: Single Run, Sweeps and Corners
Tests:
  project_tb_dff_1b_1: project/tb_dff_1b/schematic, simulator spectre
