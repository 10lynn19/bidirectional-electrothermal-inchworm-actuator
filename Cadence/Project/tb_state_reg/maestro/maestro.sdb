ADE simulation setup
Run mode: Single Run, Sweeps and Corners
Tests:
  project_tb_state_reg_1: project/tb_state_reg/schematic, simulator spectre
