ADE simulation setup
Run mode: Single Run, Sweeps and Corners
Tests:
  project_tb_fsm_1: project/tb_fsm/schematic, simulator spectre
