ADE simulation setup
Run mode: Single Run, Sweeps and Corners
Tests:
  project_tb_inv_and_or_1: project/tb_inv_and_or/schematic, simulator spectre
