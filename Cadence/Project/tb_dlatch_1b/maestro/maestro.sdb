ADE simulation setup
Run mode: Single Run, Sweeps and Corners
Tests:
  project_tb_dlatch_1b_1: project/tb_dlatch_1b/schematic, simulator spectre
