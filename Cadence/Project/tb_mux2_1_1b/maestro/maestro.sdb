ADE simulation setup
Run mode: Single Run, Sweeps and Corners
Tests:
  project_tb_mux2_1_1b_1: project/tb_mux2_1_1b/schematic, simulator spectre
