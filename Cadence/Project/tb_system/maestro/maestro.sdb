ADE simulation setup
Run mode: Single Run, Sweeps and Corners
Tests:
  project_tb_system_1: project/tb_system/schematic, simulator spectre
