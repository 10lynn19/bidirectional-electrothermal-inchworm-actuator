ADE simulation setup
Run mode: Single Run, Sweeps and Corners
Tests:
  project_tb_external_nv_driver_5ch_1: project/tb_external_nv_driver_5ch/schematic, simulator spectre
