ADE simulation setup
Run mode: Single Run, Sweeps and Corners
Tests:
  project_one_channel_drive_1: project/one_channel_drive/schematic, simulator spectre
