ADE simulation setup
Run mode: Single Run, Sweeps and Corners
Tests:
  project_tb_multi_channel_drive_1: project/tb_multi_channel_drive/schematic, simulator spectre
