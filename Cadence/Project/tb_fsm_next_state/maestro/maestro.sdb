ADE simulation setup
Run mode: Single Run, Sweeps and Corners
Tests:
  project_tb_fsm_next_state_1: project/tb_fsm_next_state/schematic, simulator spectre
