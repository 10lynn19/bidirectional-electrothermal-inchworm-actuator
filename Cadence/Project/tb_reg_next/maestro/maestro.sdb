ADE simulation setup
Run mode: Single Run, Sweeps and Corners
Tests:
  project_tb_reg_next_1: project/tb_reg_next/schematic, simulator spectre
