ADE simulation setup
Run mode: Single Run, Sweeps and Corners
Tests:
  project_tb_pair_decoder_1: project/tb_pair_decoder/schematic, simulator spectre
